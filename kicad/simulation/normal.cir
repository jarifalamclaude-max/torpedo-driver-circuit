* torpedo driver v4 - generated from the PCB file, scenario normal
.param VB=16.8
.include models.lib
Riso gndl 0 1G
Ciso gndl 0 10p
C1 vbat c1m 470u IC={VB}
RC1 c1m 0 0.08
C11 vbat g3 100n
C3 sbat 0 100n
C4 vg 0 100n
C5 ssw 0 100n
C6 sd1 0 100n
C7 sd2 0 100n
C8 vpre c8m 10u
RC8esr c8m 0 1
C9 n3v3p c9m 10u
RC9esr c9m 0 1
D1 d1n vsw DUF5408
D2 d2n vsw DUF5408
D3 n5v_in p5v D1N5819
D4 0 vbat DTVS22
D5 0 vg DZ12
D6 g3 vbat DZ15
D7 0 vpre DZ20
RF1 vfuse vbat 0.03
RF2 vbat_in vfuse 0.02
VBAT bat 0 {VB}
Rbat bat nb1 0.03
Lwire nb1 vbat_in 0.5u
Vsens1 vsw s1a 0
XSOL1 s1a d1n SOLENOID R=15 LO=25m LC=75m S=8m M=30m K=200 F0=0.8 C=2
Vsens2 vsw s2a 0
XSOL2 s2a d2n SOLENOID R=15 LO=25m LC=75m S=8m M=30m K=200 F0=0.8 C=2
Vlogic l5 gndl 5.1
Rlogic l5 n5v_in 0.1
DLED1 led1a 0 DLED
DLED2 led2a 0 DLED
XQ1 d1n g1 0 IRLZ44N VTO=1.75
XQ2 d2n g2 0 IRLZ44N VTO=1.75
XQ3 vsw g3 vbat IRF4905 VTO=-3.0
R1 fire1 ol1 150
R10 vsw ssw 200000
R11 0 ssw 20000
R12 vbat vsw 68000
R13 vbat g3 4700
R14 g3d g3 1000
R15 arm ol3 150
R16 scl_tx oscl 220
R17 sda_tx osda 220
R18 n3v3p u7a 1000
R19 n3v3l sda_rx 6800
R2 fire2 ol2 150
R20 scl_p n3v3p 10000
R21 sda_p n3v3p 10000
R22 d1n sd1 200000
R23 0 sd1 20000
R24 d2n sd2 200000
R25 0 sd2 20000
R26 vbat vpre 1000
R3 g1 0 4700
R4 g2 0 4700
R5 vbat sbat 200000
R6 0 sbat 20000
R7 g1 led1a 10000
R8 g2 led2a 10000
R9 vg vsw 680
Resp p5v gndl 82
V3v3 v3i gndl 3.3
R3v3 v3i n3v3l 1
Vgpio1 gp1i gndl PWL(0 0 30m 0 30.001m 3.3 230m 3.3 230.001m 0)
Rgpio1 gp1i fire1 40
Vgpio0 gp0i gndl DC 0
Rgpio0 gp0i fire2 40
Vgpio5 gp5i gndl DC 0
Rgpio5 gp5i scl_tx 40
Vgpio6 gp6i gndl DC 0
Rgpio6 gp6i sda_tx 40
Rin7 sda_rx gndl 10meg
Vgpio10 gp10i gndl PWL(0 0 20m 0 20.001m 3.3 330m 3.3 330.001m 0)
Rgpio10 gp10i arm 40
XU2 ol1 gndl vg g1 PC817 CTR=1.0 CJC=15p
XU3 ol2 gndl vg g2 PC817 CTR=1.0 CJC=15p
XU4 ol3 gndl g3d 0 PC817 CTR=1.0 CJC=15p
XU5 oscl gndl scl_p 0 PC817 CTR=1.0 CJC=15p
XU6 osda gndl sda_p 0 PC817 CTR=1.0 CJC=15p
XU7 u7a sda_p sda_rx gndl PC817 CTR=1.0 CJC=15p
XU8 n3v3p 0 vpre LDO33
Iads n3v3p 0 200u
Radc7 sbat 0 6meg
Radc8 ssw 0 6meg
Radc9 sd1 0 6meg
Radc10 sd2 0 6meg
Rmpu1 scl_p n3v3p 10k
Rmpu2 sda_p n3v3p 10k
.options method=gear reltol=1e-4 itl4=100
.tran 10u 400m 0 20u uic
.control
set noaskquit
run
let ratio = v(vsw)/v(vbat)
let vgs3 = v(g3)-v(vbat)
let isol1 = abs(i(vsens1))
let x1 = v(xsol1.x)
let vds3 = v(vbat)-v(vsw)
let led1_ma = (v(g1)-v(led1a))/10
let iopto1_ma = -i(vgpio1)*1000
let d1n_vsw = v(d1n)/v(vsw)
let d2n_vsw = v(d2n)/v(vsw)
let isol2 = abs(i(vsens2))
let x2 = v(xsol2.x)
let ibat = abs(i(vbat))
meas tran ratio_idle find ratio at=15m
meas tran vsw_idle find v(vsw) at=15m
meas tran d1n_idle find v(d1n) at=15m
meas tran d2n_idle find v(d2n) at=15m
meas tran adc_bat_idle find v(sbat) at=15m
meas tran adc_sw_idle find v(ssw) at=15m
meas tran adc_d1_idle find v(sd1) at=15m
meas tran adc_d2_idle find v(sd2) at=15m
meas tran vg_idle find v(vg) at=15m
meas tran g1_idle find v(g1) at=15m
meas tran vgs3_idle find vgs3 at=15m
meas tran v3v3p find v(n3v3p) at=15m
meas tran ratio_armed find ratio at=28m
meas tran vgs3_on find vgs3 at=28m
meas tran vg_armed find v(vg) at=28m
meas tran g1_arm_max max v(g1) from=20m to=29m
meas tran g2_arm_max max v(g2) from=20m to=29m
meas tran isol1_arm_max max isol1 from=20m to=29m
meas tran ipeak1 max isol1 from=30m to=230m
meas tran i1_end find isol1 at=229m
meas tran t_pullin when x1=0.0076 rise=1
meas tran x1_max max x1 from=30m to=230m
meas tran vgs1_on find v(g1) at=150m
meas tran vds1_on find v(d1n) at=150m
meas tran vds3_on find vds3 at=150m
meas tran vgs3_fire find vgs3 at=150m
meas tran vg_fire find v(vg) at=150m
meas tran vsw_fire find v(vsw) at=150m
meas tran adc_d1_fire find v(sd1) at=150m
meas tran adc_sw_fire find v(ssw) at=150m
meas tran adc_bat_fire find v(sbat) at=150m
meas tran led1_ma find led1_ma at=150m
meas tran iopto1_ma find iopto1_ma at=150m
meas tran vd1n_flyback max v(d1n) from=229m to=260m
meas tran t_release when x1=0.5m fall=1
meas tran vbat_min min v(vbat) from=0 to=399m
meas tran vsw_max max v(vsw) from=0 to=399m
meas tran vg_max max v(vg) from=0 to=399m
meas tran g1_max max v(g1) from=0 to=399m
meas tran ratio_after find ratio at=395m
wrdata out/normal.dat isol1 x1 v(vsw) v(d1n) v(g1) v(g3) v(vbat) v(vg) v(sd1) v(ssw)
.endc
.end
